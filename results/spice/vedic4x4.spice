* NGSPICE file created from vedic4x4.ext - technology: sky130A

* Black-box entry subcircuit for sky130_fd_sc_hd__decap_6 abstract view
.subckt sky130_fd_sc_hd__decap_6 VGND VNB VPB VPWR
.ends

* Black-box entry subcircuit for sky130_fd_sc_hd__decap_8 abstract view
.subckt sky130_fd_sc_hd__decap_8 VGND VNB VPB VPWR
.ends

* Black-box entry subcircuit for sky130_fd_sc_hd__and2_1 abstract view
.subckt sky130_fd_sc_hd__and2_1 A B VGND VNB VPB VPWR X
.ends

* Black-box entry subcircuit for sky130_fd_sc_hd__nor2_1 abstract view
.subckt sky130_fd_sc_hd__nor2_1 A B VGND VNB VPB VPWR Y
.ends

* Black-box entry subcircuit for sky130_fd_sc_hd__clkbuf_4 abstract view
.subckt sky130_fd_sc_hd__clkbuf_4 A VGND VNB VPB VPWR X
.ends

* Black-box entry subcircuit for sky130_fd_sc_hd__fill_2 abstract view
.subckt sky130_fd_sc_hd__fill_2 VGND VNB VPB VPWR
.ends

* Black-box entry subcircuit for sky130_fd_sc_hd__a22oi_1 abstract view
.subckt sky130_fd_sc_hd__a22oi_1 A1 A2 B1 B2 VGND VNB VPB VPWR Y
.ends

* Black-box entry subcircuit for sky130_fd_sc_hd__fill_1 abstract view
.subckt sky130_fd_sc_hd__fill_1 VGND VNB VPB VPWR
.ends

* Black-box entry subcircuit for sky130_fd_sc_hd__decap_3 abstract view
.subckt sky130_fd_sc_hd__decap_3 VGND VNB VPB VPWR
.ends

* Black-box entry subcircuit for sky130_ef_sc_hd__decap_12 abstract view
.subckt sky130_ef_sc_hd__decap_12 VPWR VGND VPB VNB
.ends

* Black-box entry subcircuit for sky130_fd_sc_hd__decap_4 abstract view
.subckt sky130_fd_sc_hd__decap_4 VGND VNB VPB VPWR
.ends

* Black-box entry subcircuit for sky130_fd_sc_hd__a2bb2o_1 abstract view
.subckt sky130_fd_sc_hd__a2bb2o_1 A1_N A2_N B1 B2 VGND VNB VPB VPWR X
.ends

* Black-box entry subcircuit for sky130_fd_sc_hd__xnor2_1 abstract view
.subckt sky130_fd_sc_hd__xnor2_1 A B VGND VNB VPB VPWR Y
.ends

* Black-box entry subcircuit for sky130_fd_sc_hd__buf_2 abstract view
.subckt sky130_fd_sc_hd__buf_2 A VGND VNB VPB VPWR X
.ends

* Black-box entry subcircuit for sky130_fd_sc_hd__nand2_1 abstract view
.subckt sky130_fd_sc_hd__nand2_1 A B VGND VNB VPB VPWR Y
.ends

* Black-box entry subcircuit for sky130_fd_sc_hd__xor2_1 abstract view
.subckt sky130_fd_sc_hd__xor2_1 A B VGND VNB VPB VPWR X
.ends

* Black-box entry subcircuit for sky130_fd_sc_hd__o21ai_1 abstract view
.subckt sky130_fd_sc_hd__o21ai_1 A1 A2 B1 VGND VNB VPB VPWR Y
.ends

* Black-box entry subcircuit for sky130_fd_sc_hd__and3_1 abstract view
.subckt sky130_fd_sc_hd__and3_1 A B C VGND VNB VPB VPWR X
.ends

* Black-box entry subcircuit for sky130_fd_sc_hd__mux2_1 abstract view
.subckt sky130_fd_sc_hd__mux2_1 A0 A1 S VGND VNB VPB VPWR X
.ends

* Black-box entry subcircuit for sky130_fd_sc_hd__dlymetal6s2s_1 abstract view
.subckt sky130_fd_sc_hd__dlymetal6s2s_1 A VGND VNB VPB VPWR X
.ends

* Black-box entry subcircuit for sky130_fd_sc_hd__or3_1 abstract view
.subckt sky130_fd_sc_hd__or3_1 A B C VGND VNB VPB VPWR X
.ends

* Black-box entry subcircuit for sky130_fd_sc_hd__and4_1 abstract view
.subckt sky130_fd_sc_hd__and4_1 A B C D VGND VNB VPB VPWR X
.ends

* Black-box entry subcircuit for sky130_fd_sc_hd__clkbuf_2 abstract view
.subckt sky130_fd_sc_hd__clkbuf_2 A VGND VNB VPB VPWR X
.ends

* Black-box entry subcircuit for sky130_fd_sc_hd__o21bai_1 abstract view
.subckt sky130_fd_sc_hd__o21bai_1 A1 A2 B1_N VGND VNB VPB VPWR Y
.ends

* Black-box entry subcircuit for sky130_fd_sc_hd__a21bo_1 abstract view
.subckt sky130_fd_sc_hd__a21bo_1 A1 A2 B1_N VGND VNB VPB VPWR X
.ends

* Black-box entry subcircuit for sky130_fd_sc_hd__a21oi_1 abstract view
.subckt sky130_fd_sc_hd__a21oi_1 A1 A2 B1 VGND VNB VPB VPWR Y
.ends

* Black-box entry subcircuit for sky130_fd_sc_hd__a31o_1 abstract view
.subckt sky130_fd_sc_hd__a31o_1 A1 A2 A3 B1 VGND VNB VPB VPWR X
.ends

* Black-box entry subcircuit for sky130_fd_sc_hd__tapvpwrvgnd_1 abstract view
.subckt sky130_fd_sc_hd__tapvpwrvgnd_1 VGND VPWR
.ends

* Black-box entry subcircuit for sky130_fd_sc_hd__a21o_1 abstract view
.subckt sky130_fd_sc_hd__a21o_1 A1 A2 B1 VGND VNB VPB VPWR X
.ends

* Black-box entry subcircuit for sky130_fd_sc_hd__and2b_1 abstract view
.subckt sky130_fd_sc_hd__and2b_1 A_N B VGND VNB VPB VPWR X
.ends

* Black-box entry subcircuit for sky130_fd_sc_hd__a22o_1 abstract view
.subckt sky130_fd_sc_hd__a22o_1 A1 A2 B1 B2 VGND VNB VPB VPWR X
.ends

* Black-box entry subcircuit for sky130_fd_sc_hd__clkbuf_1 abstract view
.subckt sky130_fd_sc_hd__clkbuf_1 A VGND VNB VPB VPWR X
.ends

* Black-box entry subcircuit for sky130_fd_sc_hd__or2b_1 abstract view
.subckt sky130_fd_sc_hd__or2b_1 A B_N VGND VNB VPB VPWR X
.ends

* Black-box entry subcircuit for sky130_fd_sc_hd__nand3_1 abstract view
.subckt sky130_fd_sc_hd__nand3_1 A B C VGND VNB VPB VPWR Y
.ends

* Black-box entry subcircuit for sky130_fd_sc_hd__a21boi_1 abstract view
.subckt sky130_fd_sc_hd__a21boi_1 A1 A2 B1_N VGND VNB VPB VPWR Y
.ends

* Black-box entry subcircuit for sky130_fd_sc_hd__nand4_1 abstract view
.subckt sky130_fd_sc_hd__nand4_1 A B C D VGND VNB VPB VPWR Y
.ends

.subckt vedic4x4 A[0] A[1] A[2] A[3] B[0] B[1] B[2] B[3] P[0] P[1] P[2] P[3] P[4]
+ P[5] P[6] P[7] VGND VPWR
XFILLER_0_9_49 VGND VGND VPWR VPWR sky130_fd_sc_hd__decap_6
XFILLER_0_0_29 VGND VGND VPWR VPWR sky130_fd_sc_hd__decap_8
X_062_ net2 net7 VGND VGND VPWR VPWR _013_ sky130_fd_sc_hd__and2_1
X_061_ _010_ _011_ VGND VGND VPWR VPWR _012_ sky130_fd_sc_hd__nor2_1
Xoutput10 net10 VGND VGND VPWR VPWR P[1] sky130_fd_sc_hd__clkbuf_4
XFILLER_0_10_65 VGND VGND VPWR VPWR sky130_fd_sc_hd__fill_2
XFILLER_0_9_29 VGND VGND VPWR VPWR sky130_fd_sc_hd__fill_2
X_060_ net3 net7 net4 net6 VGND VGND VPWR VPWR _011_ sky130_fd_sc_hd__a22oi_1
Xoutput9 net9 VGND VGND VPWR VPWR P[0] sky130_fd_sc_hd__clkbuf_4
Xoutput11 net11 VGND VGND VPWR VPWR P[2] sky130_fd_sc_hd__clkbuf_4
XFILLER_0_4_41 VGND VGND VPWR VPWR sky130_fd_sc_hd__fill_2
Xoutput12 net12 VGND VGND VPWR VPWR P[3] sky130_fd_sc_hd__clkbuf_4
XFILLER_0_1_42 VGND VGND VPWR VPWR sky130_fd_sc_hd__fill_1
XFILLER_0_4_20 VGND VGND VPWR VPWR sky130_fd_sc_hd__decap_8
XFILLER_0_7_53 VGND VGND VPWR VPWR sky130_fd_sc_hd__decap_3
Xoutput13 net13 VGND VGND VPWR VPWR P[4] sky130_fd_sc_hd__clkbuf_4
XFILLER_0_10_57 VGND VGND VPWR VPWR sky130_fd_sc_hd__fill_2
XFILLER_0_10_35 VPWR VGND VPWR VGND sky130_ef_sc_hd__decap_12
XFILLER_0_1_33 VGND VGND VPWR VPWR sky130_fd_sc_hd__decap_6
XFILLER_0_1_55 VGND VGND VPWR VPWR sky130_fd_sc_hd__fill_1
Xoutput14 net14 VGND VGND VPWR VPWR P[5] sky130_fd_sc_hd__clkbuf_4
XFILLER_0_7_32 VGND VGND VPWR VPWR sky130_fd_sc_hd__fill_1
XPHY_0 VGND VGND VPWR VPWR sky130_fd_sc_hd__decap_3
XFILLER_0_7_3 VGND VGND VPWR VPWR sky130_fd_sc_hd__decap_6
XFILLER_0_10_47 VGND VGND VPWR VPWR sky130_fd_sc_hd__decap_4
X_099_ _041_ _042_ _043_ _044_ VGND VGND VPWR VPWR net16 sky130_fd_sc_hd__a2bb2o_1
Xoutput15 net15 VGND VGND VPWR VPWR P[6] sky130_fd_sc_hd__clkbuf_4
XPHY_1 VGND VGND VPWR VPWR sky130_fd_sc_hd__decap_3
XFILLER_0_7_44 VGND VGND VPWR VPWR sky130_fd_sc_hd__fill_2
X_098_ _007_ _045_ VGND VGND VPWR VPWR net12 sky130_fd_sc_hd__xnor2_1
XPHY_2 VGND VGND VPWR VPWR sky130_fd_sc_hd__decap_3
Xoutput16 net16 VGND VGND VPWR VPWR P[7] sky130_fd_sc_hd__buf_2
XFILLER_0_10_27 VGND VGND VPWR VPWR sky130_fd_sc_hd__fill_1
X_097_ _027_ _028_ VGND VGND VPWR VPWR _045_ sky130_fd_sc_hd__nand2_1
XFILLER_0_9_9 VPWR VGND VPWR VGND sky130_ef_sc_hd__decap_12
XPHY_3 VGND VGND VPWR VPWR sky130_fd_sc_hd__decap_3
XFILLER_0_4_14 VGND VGND VPWR VPWR sky130_fd_sc_hd__fill_1
XFILLER_0_4_47 VPWR VGND VPWR VGND sky130_ef_sc_hd__decap_12
XFILLER_0_1_15 VGND VGND VPWR VPWR sky130_fd_sc_hd__fill_2
XFILLER_0_1_48 VGND VGND VPWR VPWR sky130_fd_sc_hd__fill_1
X_096_ _043_ _044_ VGND VGND VPWR VPWR net15 sky130_fd_sc_hd__xor2_1
X_079_ _026_ _029_ VGND VGND VPWR VPWR net13 sky130_fd_sc_hd__xor2_1
XPHY_4 VGND VGND VPWR VPWR sky130_fd_sc_hd__decap_3
XFILLER_0_4_59 VGND VGND VPWR VPWR sky130_fd_sc_hd__decap_8
XFILLER_0_10_29 VGND VGND VPWR VPWR sky130_fd_sc_hd__fill_2
X_095_ _039_ _036_ _037_ VGND VGND VPWR VPWR _044_ sky130_fd_sc_hd__o21ai_1
X_078_ _007_ _027_ _028_ VGND VGND VPWR VPWR _029_ sky130_fd_sc_hd__and3_1
XPHY_5 VGND VGND VPWR VPWR sky130_fd_sc_hd__decap_3
XFILLER_0_10_19 VGND VGND VPWR VPWR sky130_fd_sc_hd__decap_8
X_094_ _041_ _010_ _042_ VGND VGND VPWR VPWR _043_ sky130_fd_sc_hd__mux2_1
X_077_ _024_ _023_ _019_ VGND VGND VPWR VPWR _028_ sky130_fd_sc_hd__o21ai_1
XPHY_6 VGND VGND VPWR VPWR sky130_fd_sc_hd__decap_3
X_093_ net4 net8 VGND VGND VPWR VPWR _042_ sky130_fd_sc_hd__nand2_1
XFILLER_0_3_3 VGND VGND VPWR VPWR sky130_fd_sc_hd__decap_4
Xinput1 A[0] VGND VGND VPWR VPWR net1 sky130_fd_sc_hd__dlymetal6s2s_1
X_076_ _024_ _019_ _023_ VGND VGND VPWR VPWR _027_ sky130_fd_sc_hd__or3_1
XFILLER_0_7_28 VGND VGND VPWR VPWR sky130_fd_sc_hd__fill_1
X_059_ net6 net3 net7 net4 VGND VGND VPWR VPWR _010_ sky130_fd_sc_hd__and4_1
XPHY_7 VGND VGND VPWR VPWR sky130_fd_sc_hd__decap_3
XFILLER_0_4_29 VPWR VGND VPWR VGND sky130_ef_sc_hd__decap_12
Xinput2 A[1] VGND VGND VPWR VPWR net2 sky130_fd_sc_hd__clkbuf_2
X_092_ net3 net7 VGND VGND VPWR VPWR _041_ sky130_fd_sc_hd__nand2_1
XPHY_8 VGND VGND VPWR VPWR sky130_fd_sc_hd__decap_3
X_058_ net2 net8 VGND VGND VPWR VPWR _009_ sky130_fd_sc_hd__nand2_1
X_075_ _018_ _025_ VGND VGND VPWR VPWR _026_ sky130_fd_sc_hd__xor2_1
XFILLER_0_5_40 VGND VGND VPWR VPWR sky130_fd_sc_hd__decap_3
Xinput3 A[2] VGND VGND VPWR VPWR net3 sky130_fd_sc_hd__buf_2
X_091_ _038_ _040_ VGND VGND VPWR VPWR net14 sky130_fd_sc_hd__xnor2_1
X_074_ _019_ _023_ _024_ VGND VGND VPWR VPWR _025_ sky130_fd_sc_hd__o21bai_1
X_057_ _007_ _008_ VGND VGND VPWR VPWR net11 sky130_fd_sc_hd__nor2_1
XPHY_9 VGND VGND VPWR VPWR sky130_fd_sc_hd__decap_3
XFILLER_0_5_9 VGND VGND VPWR VPWR sky130_fd_sc_hd__decap_3
X_090_ _026_ _029_ _039_ VGND VGND VPWR VPWR _040_ sky130_fd_sc_hd__a21bo_1
Xinput4 A[3] VGND VGND VPWR VPWR net4 sky130_fd_sc_hd__dlymetal6s2s_1
X_056_ _001_ _006_ VGND VGND VPWR VPWR _008_ sky130_fd_sc_hd__nor2_1
X_073_ _020_ _022_ _021_ VGND VGND VPWR VPWR _024_ sky130_fd_sc_hd__and3_1
XFILLER_0_3_7 VGND VGND VPWR VPWR sky130_fd_sc_hd__fill_1
Xinput5 B[0] VGND VGND VPWR VPWR net5 sky130_fd_sc_hd__clkbuf_2
X_072_ _020_ _021_ _022_ VGND VGND VPWR VPWR _023_ sky130_fd_sc_hd__a21oi_1
X_055_ _001_ _006_ VGND VGND VPWR VPWR _007_ sky130_fd_sc_hd__and2_1
XFILLER_0_8_64 VGND VGND VPWR VPWR sky130_fd_sc_hd__decap_3
XFILLER_0_5_65 VGND VGND VPWR VPWR sky130_fd_sc_hd__fill_2
X_071_ net1 net7 _004_ _003_ VGND VGND VPWR VPWR _022_ sky130_fd_sc_hd__a31o_1
Xinput6 B[1] VGND VGND VPWR VPWR net6 sky130_fd_sc_hd__buf_2
X_054_ _002_ _005_ VGND VGND VPWR VPWR _006_ sky130_fd_sc_hd__xnor2_1
XTAP_30 VGND VPWR sky130_fd_sc_hd__tapvpwrvgnd_1
Xinput7 B[2] VGND VGND VPWR VPWR net7 sky130_fd_sc_hd__clkbuf_2
X_070_ _015_ _014_ _013_ VGND VGND VPWR VPWR _021_ sky130_fd_sc_hd__a21o_1
X_053_ _003_ _004_ VGND VGND VPWR VPWR _005_ sky130_fd_sc_hd__and2b_1
XFILLER_0_8_44 VGND VGND VPWR VPWR sky130_fd_sc_hd__fill_1
XFILLER_0_1_7 VGND VGND VPWR VPWR sky130_fd_sc_hd__decap_8
XTAP_31 VGND VPWR sky130_fd_sc_hd__tapvpwrvgnd_1
Xinput8 B[3] VGND VGND VPWR VPWR net8 sky130_fd_sc_hd__dlymetal6s2s_1
X_052_ net2 net6 net3 net5 VGND VGND VPWR VPWR _004_ sky130_fd_sc_hd__a22o_1
XTAP_32 VGND VPWR sky130_fd_sc_hd__tapvpwrvgnd_1
XFILLER_0_5_57 VGND VGND VPWR VPWR sky130_fd_sc_hd__decap_8
X_051_ net2 net5 net6 net3 VGND VGND VPWR VPWR _003_ sky130_fd_sc_hd__and4_1
XTAP_33 VGND VPWR sky130_fd_sc_hd__tapvpwrvgnd_1
XTAP_22 VGND VPWR sky130_fd_sc_hd__tapvpwrvgnd_1
X_050_ net1 net7 VGND VGND VPWR VPWR _002_ sky130_fd_sc_hd__nand2_1
XTAP_34 VGND VPWR sky130_fd_sc_hd__tapvpwrvgnd_1
XFILLER_0_10_7 VGND VGND VPWR VPWR sky130_fd_sc_hd__decap_6
XFILLER_0_8_3 VGND VGND VPWR VPWR sky130_fd_sc_hd__fill_2
XTAP_23 VGND VPWR sky130_fd_sc_hd__tapvpwrvgnd_1
XFILLER_0_5_48 VGND VGND VPWR VPWR sky130_fd_sc_hd__decap_8
X_101_ _046_ VGND VGND VPWR VPWR net9 sky130_fd_sc_hd__clkbuf_1
XFILLER_0_5_16 VPWR VGND VPWR VGND sky130_ef_sc_hd__decap_12
XTAP_24 VGND VPWR sky130_fd_sc_hd__tapvpwrvgnd_1
X_100_ net5 net1 VGND VGND VPWR VPWR _046_ sky130_fd_sc_hd__and2_1
XFILLER_0_8_27 VGND VGND VPWR VPWR sky130_fd_sc_hd__fill_1
XTAP_25 VGND VPWR sky130_fd_sc_hd__tapvpwrvgnd_1
XFILLER_0_5_28 VPWR VGND VPWR VGND sky130_ef_sc_hd__decap_12
XPHY_20 VGND VGND VPWR VPWR sky130_fd_sc_hd__decap_3
XFILLER_0_9_60 VGND VGND VPWR VPWR sky130_fd_sc_hd__fill_1
XPHY_21 VGND VGND VPWR VPWR sky130_fd_sc_hd__decap_3
XTAP_26 VGND VPWR sky130_fd_sc_hd__tapvpwrvgnd_1
XPHY_10 VGND VGND VPWR VPWR sky130_fd_sc_hd__decap_3
XFILLER_0_6_3 VGND VGND VPWR VPWR sky130_fd_sc_hd__decap_6
X_089_ _018_ _025_ VGND VGND VPWR VPWR _039_ sky130_fd_sc_hd__nand2_1
XTAP_27 VGND VPWR sky130_fd_sc_hd__tapvpwrvgnd_1
XPHY_11 VGND VGND VPWR VPWR sky130_fd_sc_hd__decap_3
X_088_ _036_ _037_ VGND VGND VPWR VPWR _038_ sky130_fd_sc_hd__or2b_1
XTAP_28 VGND VPWR sky130_fd_sc_hd__tapvpwrvgnd_1
XPHY_12 VGND VGND VPWR VPWR sky130_fd_sc_hd__decap_3
X_087_ _030_ _031_ _035_ VGND VGND VPWR VPWR _037_ sky130_fd_sc_hd__a21o_1
XFILLER_0_0_21 VGND VGND VPWR VPWR sky130_fd_sc_hd__decap_6
XPHY_13 VGND VGND VPWR VPWR sky130_fd_sc_hd__decap_3
XTAP_29 VGND VPWR sky130_fd_sc_hd__tapvpwrvgnd_1
XFILLER_0_4_3 VGND VGND VPWR VPWR sky130_fd_sc_hd__decap_8
XFILLER_0_3_65 VGND VGND VPWR VPWR sky130_fd_sc_hd__fill_2
X_086_ _030_ _031_ _035_ VGND VGND VPWR VPWR _036_ sky130_fd_sc_hd__and3_1
XFILLER_0_0_44 VPWR VGND VPWR VGND sky130_ef_sc_hd__decap_12
X_069_ _015_ _013_ _014_ VGND VGND VPWR VPWR _020_ sky130_fd_sc_hd__nand3_1
XFILLER_0_6_32 VGND VGND VPWR VPWR sky130_fd_sc_hd__decap_4
XPHY_14 VGND VGND VPWR VPWR sky130_fd_sc_hd__decap_3
X_085_ _033_ _034_ VGND VGND VPWR VPWR _035_ sky130_fd_sc_hd__xor2_1
XFILLER_0_9_21 VGND VGND VPWR VPWR sky130_fd_sc_hd__decap_8
X_068_ net1 net8 VGND VGND VPWR VPWR _019_ sky130_fd_sc_hd__nand2_1
XPHY_15 VGND VGND VPWR VPWR sky130_fd_sc_hd__decap_3
XFILLER_0_9_55 VGND VGND VPWR VPWR sky130_fd_sc_hd__fill_1
X_084_ net3 net8 VGND VGND VPWR VPWR _034_ sky130_fd_sc_hd__nand2_1
XFILLER_0_0_57 VGND VGND VPWR VPWR sky130_fd_sc_hd__decap_6
X_067_ _009_ _017_ VGND VGND VPWR VPWR _018_ sky130_fd_sc_hd__xnor2_1
XPHY_16 VGND VGND VPWR VPWR sky130_fd_sc_hd__decap_3
XFILLER_0_2_3 VGND VGND VPWR VPWR sky130_fd_sc_hd__fill_2
X_083_ net7 net4 _032_ VGND VGND VPWR VPWR _033_ sky130_fd_sc_hd__and3_1
XFILLER_0_3_35 VGND VGND VPWR VPWR sky130_fd_sc_hd__decap_3
XFILLER_0_3_57 VGND VGND VPWR VPWR sky130_fd_sc_hd__decap_8
X_049_ _000_ _001_ VGND VGND VPWR VPWR net10 sky130_fd_sc_hd__nor2_1
X_066_ _012_ _016_ VGND VGND VPWR VPWR _017_ sky130_fd_sc_hd__xnor2_1
XPHY_17 VGND VGND VPWR VPWR sky130_fd_sc_hd__decap_3
XFILLER_0_0_37 VGND VGND VPWR VPWR sky130_fd_sc_hd__fill_1
X_082_ net6 net3 VGND VGND VPWR VPWR _032_ sky130_fd_sc_hd__nand2_1
X_065_ _013_ _014_ _015_ VGND VGND VPWR VPWR _016_ sky130_fd_sc_hd__a21boi_1
X_048_ net2 net5 net6 net1 VGND VGND VPWR VPWR _001_ sky130_fd_sc_hd__and4_1
XPHY_18 VGND VGND VPWR VPWR sky130_fd_sc_hd__decap_3
XFILLER_0_6_36 VGND VGND VPWR VPWR sky130_fd_sc_hd__fill_1
X_081_ _009_ _017_ VGND VGND VPWR VPWR _031_ sky130_fd_sc_hd__or2b_1
XFILLER_0_9_36 VGND VGND VPWR VPWR sky130_fd_sc_hd__decap_6
XFILLER_0_0_27 VGND VGND VPWR VPWR sky130_fd_sc_hd__fill_1
X_064_ net5 net6 net3 net4 VGND VGND VPWR VPWR _015_ sky130_fd_sc_hd__nand4_1
XPHY_19 VGND VGND VPWR VPWR sky130_fd_sc_hd__decap_3
XFILLER_0_6_48 VGND VGND VPWR VPWR sky130_fd_sc_hd__decap_3
XFILLER_0_6_15 VPWR VGND VPWR VGND sky130_ef_sc_hd__decap_12
X_047_ net2 net5 net6 net1 VGND VGND VPWR VPWR _000_ sky130_fd_sc_hd__a22oi_1
XFILLER_0_3_27 VGND VGND VPWR VPWR sky130_fd_sc_hd__decap_8
XFILLER_0_0_3 VGND VGND VPWR VPWR sky130_fd_sc_hd__fill_2
X_080_ _010_ _011_ _016_ VGND VGND VPWR VPWR _030_ sky130_fd_sc_hd__or3_1
X_063_ net6 net3 net4 net5 VGND VGND VPWR VPWR _014_ sky130_fd_sc_hd__a22o_1
XFILLER_0_10_51 VGND VGND VPWR VPWR sky130_fd_sc_hd__fill_1
XFILLER_0_6_27 VGND VGND VPWR VPWR sky130_fd_sc_hd__fill_1
.ends
